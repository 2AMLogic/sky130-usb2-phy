* driver-static-pex -- sky130 FS line driver, static bench, post-layout (klt pex)
*
* Post-layout counterpart of sim/driver-static: identical circuit body, measurements and
* checks. The single .include below names the schematic-leg DUT shim
* (differential_driver_pex_dut.spice: design/netlist/differential_driver.spice with its
* .subckt declaration line reordered to the extracted header's pin order) -- the swap
* point klt pex re-points at the extracted netlist for the extracted-side leg. Every
* differential_driver instance line's nets are reordered to the same pin sequence (same
* net-to-pin mapping on both legs). The request supplies the .lib corner section, .temp
* and the supply value of vsup (3.3 / 3.6 V here).

.include "differential_driver_pex_dut.spice"

vsup vdd 0 dc 3.3
ehalf mid 0 vol='v(vdd)/2'
vpu pu 0 dc 3.6
vf f 0 dc 0

xtt_d00_e00 tt_dm_d00_e00 tt_dp_d00_e00 0 0 0 0 vdd 0 differential_driver
rttp_d00_e00 tt_dp_d00_e00 mid 10k
rttm_d00_e00 tt_dm_d00_e00 mid 10k
xtt_d00_e01 tt_dm_d00_e01 tt_dp_d00_e01 0 vdd 0 0 vdd 0 differential_driver
rttp_d00_e01 tt_dp_d00_e01 mid 10k
rttm_d00_e01 tt_dm_d00_e01 mid 10k
xtt_d00_e10 tt_dm_d00_e10 tt_dp_d00_e10 vdd 0 0 0 vdd 0 differential_driver
rttp_d00_e10 tt_dp_d00_e10 mid 10k
rttm_d00_e10 tt_dm_d00_e10 mid 10k
xtt_d00_e11 tt_dm_d00_e11 tt_dp_d00_e11 vdd vdd 0 0 vdd 0 differential_driver
rttp_d00_e11 tt_dp_d00_e11 mid 10k
rttm_d00_e11 tt_dm_d00_e11 mid 10k
xtt_d01_e00 tt_dm_d01_e00 tt_dp_d01_e00 0 0 vdd 0 vdd 0 differential_driver
rttp_d01_e00 tt_dp_d01_e00 mid 10k
rttm_d01_e00 tt_dm_d01_e00 mid 10k
xtt_d01_e01 tt_dm_d01_e01 tt_dp_d01_e01 0 vdd vdd 0 vdd 0 differential_driver
rttp_d01_e01 tt_dp_d01_e01 mid 10k
rttm_d01_e01 tt_dm_d01_e01 mid 10k
xtt_d01_e10 tt_dm_d01_e10 tt_dp_d01_e10 vdd 0 vdd 0 vdd 0 differential_driver
rttp_d01_e10 tt_dp_d01_e10 mid 10k
rttm_d01_e10 tt_dm_d01_e10 mid 10k
xtt_d01_e11 tt_dm_d01_e11 tt_dp_d01_e11 vdd vdd vdd 0 vdd 0 differential_driver
rttp_d01_e11 tt_dp_d01_e11 mid 10k
rttm_d01_e11 tt_dm_d01_e11 mid 10k
xtt_d10_e00 tt_dm_d10_e00 tt_dp_d10_e00 0 0 0 vdd vdd 0 differential_driver
rttp_d10_e00 tt_dp_d10_e00 mid 10k
rttm_d10_e00 tt_dm_d10_e00 mid 10k
xtt_d10_e01 tt_dm_d10_e01 tt_dp_d10_e01 0 vdd 0 vdd vdd 0 differential_driver
rttp_d10_e01 tt_dp_d10_e01 mid 10k
rttm_d10_e01 tt_dm_d10_e01 mid 10k
xtt_d10_e10 tt_dm_d10_e10 tt_dp_d10_e10 vdd 0 0 vdd vdd 0 differential_driver
rttp_d10_e10 tt_dp_d10_e10 mid 10k
rttm_d10_e10 tt_dm_d10_e10 mid 10k
xtt_d10_e11 tt_dm_d10_e11 tt_dp_d10_e11 vdd vdd 0 vdd vdd 0 differential_driver
rttp_d10_e11 tt_dp_d10_e11 mid 10k
rttm_d10_e11 tt_dm_d10_e11 mid 10k
xtt_d11_e00 tt_dm_d11_e00 tt_dp_d11_e00 0 0 vdd vdd vdd 0 differential_driver
rttp_d11_e00 tt_dp_d11_e00 mid 10k
rttm_d11_e00 tt_dm_d11_e00 mid 10k
xtt_d11_e01 tt_dm_d11_e01 tt_dp_d11_e01 0 vdd vdd vdd vdd 0 differential_driver
rttp_d11_e01 tt_dp_d11_e01 mid 10k
rttm_d11_e01 tt_dm_d11_e01 mid 10k
xtt_d11_e10 tt_dm_d11_e10 tt_dp_d11_e10 vdd 0 vdd vdd vdd 0 differential_driver
rttp_d11_e10 tt_dp_d11_e10 mid 10k
rttm_d11_e10 tt_dm_d11_e10 mid 10k
xtt_d11_e11 tt_dm_d11_e11 tt_dp_d11_e11 vdd vdd vdd vdd vdd 0 differential_driver
rttp_d11_e11 tt_dp_d11_e11 mid 10k
rttm_d11_e11 tt_dm_d11_e11 mid 10k

xvoh voh_dm voh_dp vdd vdd vdd vdd vdd 0 differential_driver
rvohp voh_dp 0 15k
rvohm voh_dm 0 15k
xvoh15 voh15_dm voh15_dp vdd vdd vdd vdd vdd 0 differential_driver
rvoh15p voh15_dp pu 1.5k
rvoh15m voh15_dm pu 1.5k
xvol vol_dm vol_dp vdd vdd 0 0 vdd 0 differential_driver
rvolp vol_dp pu 1.5k
rvolm vol_dm pu 1.5k

xrh rh_dm rh_dp vdd vdd vdd vdd vdd 0 differential_driver
ehf hf 0 vol='v(vdd)-0.3'
vsrhp hf rh_dp 0
vsrhm hf rh_dm 0
brhp rhv_dp 0 v='0.3/max(-i(vsrhp),1e-12)'
brhm rhv_dm 0 v='0.3/max(-i(vsrhm),1e-12)'
xrl rl_dm rl_dp vdd vdd 0 0 vdd 0 differential_driver
vlf lf 0 dc 0.3
vsrlp lf rl_dp 0
vsrlm lf rl_dm 0
brlp rlv_dp 0 v='0.3/max(i(vsrlp),1e-12)'
brlm rlv_dm 0 v='0.3/max(i(vsrlm),1e-12)'

xlka lka_dm lka_dp vdd 0 0 vdd vdd 0 differential_driver
vsap lka_dp f 0
vsam lka_dm mid 0
xlkb lkb_dm lkb_dp 0 vdd vdd 0 vdd 0 differential_driver
vsbm lkb_dm f 0
vsbp lkb_dp mid 0

vsupq vdd vddq 0
xq q_dm q_dp vdd vdd 0 vdd vddq 0 differential_driver

* ---- included: differential_driver_pex_dut.spice ----
* differential_driver_pex_dut.spice -- schematic-leg DUT for sim/diff-driver-pex
*
* design/netlist/differential_driver.spice with its .subckt declaration line's pin
* list reordered from the schematic symbol order (VDD VSS TXDP TXDM DRVEN OE DP DM) to
* the order klt extract writes the extracted header in (DM DP DRVEN OE TXDM TXDP VDD VSS,
* alphabetical; verified against the committed GDS by the probe extraction recorded in
* records/). klt pex reuses one positional instance line on both legs, so both sides must
* declare the same pin sequence. The reordered declaration is electrically identical
* (SPICE maps instance positions to the declared pin names) and every other byte is
* identical to the pinned netlist; the schematic legs must reproduce the committed
* 45-point records sim/driver-static/records/20261020-194710-ca4a45a.md and
* sim/driver-signal-quality/records/20261020-181618-ca4a45a.md before the deltas are
* read (run.py's equivalence gate).
.subckt differential_driver DM DP DRVEN OE TXDM TXDP VDD VSS
*.iopin VDD
*.iopin VSS
*.ipin TXDP
*.ipin TXDM
*.ipin DRVEN
*.ipin OE
*.iopin DP
*.iopin DM
XMP_ENA ENB DRVEN VDD VDD sky130_fd_pr__pfet_g5v0d10v5 L=0.5 W=2 nf=1 ad=0.58 as=0.58 pd=4.58
+ ps=4.58 nrd=0.145 nrs=0.145 sa=0 sb=0 sd=0 mult=1 m=1
XMP_ENB ENB OE VDD VDD sky130_fd_pr__pfet_g5v0d10v5 L=0.5 W=2 nf=1 ad=0.58 as=0.58 pd=4.58 ps=4.58
+ nrd=0.145 nrs=0.145 sa=0 sb=0 sd=0 mult=1 m=1
XMN_ENA ENB DRVEN ENX VSS sky130_fd_pr__nfet_g5v0d10v5 L=0.5 W=2 nf=1 ad=0.58 as=0.58 pd=4.58
+ ps=4.58 nrd=0.145 nrs=0.145 sa=0 sb=0 sd=0 mult=1 m=1
XMN_ENB ENX OE VSS VSS sky130_fd_pr__nfet_g5v0d10v5 L=0.5 W=2 nf=1 ad=0.58 as=0.58 pd=4.58 ps=4.58
+ nrd=0.145 nrs=0.145 sa=0 sb=0 sd=0 mult=1 m=1
XMP_ENI EN ENB VDD VDD sky130_fd_pr__pfet_g5v0d10v5 L=0.5 W=4 nf=1 ad=1.16 as=1.16 pd=8.58 ps=8.58
+ nrd=0.0725 nrs=0.0725 sa=0 sb=0 sd=0 mult=1 m=1
XMN_ENI EN ENB VSS VSS sky130_fd_pr__nfet_g5v0d10v5 L=0.5 W=2 nf=1 ad=0.58 as=0.58 pd=4.58 ps=4.58
+ nrd=0.145 nrs=0.145 sa=0 sb=0 sd=0 mult=1 m=1
XRB VBN VDD VSS sky130_fd_pr__res_xhigh_po_1p41 L=30 mult=1 m=1
XMNB VBN VBN VSS VSS sky130_fd_pr__nfet_g5v0d10v5 L=1 W=4 nf=1 ad=1.16 as=1.16 pd=8.58 ps=8.58
+ nrd=0.0725 nrs=0.0725 sa=0 sb=0 sd=0 mult=1 m=1
XMNB2 VBP VBN VSS VSS sky130_fd_pr__nfet_g5v0d10v5 L=1 W=4 nf=1 ad=1.16 as=1.16 pd=8.58 ps=8.58
+ nrd=0.0725 nrs=0.0725 sa=0 sb=0 sd=0 mult=1 m=1
XMPB VBP VBP VDD VDD sky130_fd_pr__pfet_g5v0d10v5 L=1 W=8 nf=1 ad=2.32 as=2.32 pd=16.58 ps=16.58
+ nrd=0.0362 nrs=0.0362 sa=0 sb=0 sd=0 mult=1 m=1
XMP_PA1_DP PA_DP TXDP VDD VDD sky130_fd_pr__pfet_g5v0d10v5 L=0.5 W=2 nf=1 ad=0.58 as=0.58 pd=4.58
+ ps=4.58 nrd=0.145 nrs=0.145 sa=0 sb=0 sd=0 mult=1 m=1
XMP_PA2_DP PA_DP EN VDD VDD sky130_fd_pr__pfet_g5v0d10v5 L=0.5 W=2 nf=1 ad=0.58 as=0.58 pd=4.58
+ ps=4.58 nrd=0.145 nrs=0.145 sa=0 sb=0 sd=0 mult=1 m=1
XMN_PA1_DP PA_DP TXDP PAX_DP VSS sky130_fd_pr__nfet_g5v0d10v5 L=0.5 W=2 nf=1 ad=0.58 as=0.58 pd=4.58
+ ps=4.58 nrd=0.145 nrs=0.145 sa=0 sb=0 sd=0 mult=1 m=1
XMN_PA2_DP PAX_DP EN VSS VSS sky130_fd_pr__nfet_g5v0d10v5 L=0.5 W=2 nf=1 ad=0.58 as=0.58 pd=4.58
+ ps=4.58 nrd=0.145 nrs=0.145 sa=0 sb=0 sd=0 mult=1 m=1
XMP_PINV_DP PON_DP PA_DP VDD VDD sky130_fd_pr__pfet_g5v0d10v5 L=0.5 W=8 nf=1 ad=2.32 as=2.32
+ pd=16.58 ps=16.58 nrd=0.0362 nrs=0.0362 sa=0 sb=0 sd=0 mult=1 m=1
XMN_PINV_DP PON_DP PA_DP VSS VSS sky130_fd_pr__nfet_g5v0d10v5 L=0.5 W=4 nf=1 ad=1.16 as=1.16 pd=8.58
+ ps=8.58 nrd=0.0725 nrs=0.0725 sa=0 sb=0 sd=0 mult=1 m=1
XMP_NB1_DP NBX_DP TXDP VDD VDD sky130_fd_pr__pfet_g5v0d10v5 L=0.5 W=4 nf=1 ad=1.16 as=1.16 pd=8.58
+ ps=8.58 nrd=0.0725 nrs=0.0725 sa=0 sb=0 sd=0 mult=1 m=1
XMP_NB2_DP NB_DP ENB NBX_DP VDD sky130_fd_pr__pfet_g5v0d10v5 L=0.5 W=4 nf=1 ad=1.16 as=1.16 pd=8.58
+ ps=8.58 nrd=0.0725 nrs=0.0725 sa=0 sb=0 sd=0 mult=1 m=1
XMN_NB1_DP NB_DP TXDP VSS VSS sky130_fd_pr__nfet_g5v0d10v5 L=0.5 W=1 nf=1 ad=0.29 as=0.29 pd=2.58
+ ps=2.58 nrd=0.29 nrs=0.29 sa=0 sb=0 sd=0 mult=1 m=1
XMN_NB2_DP NB_DP ENB VSS VSS sky130_fd_pr__nfet_g5v0d10v5 L=0.5 W=1 nf=1 ad=0.29 as=0.29 pd=2.58
+ ps=2.58 nrd=0.29 nrs=0.29 sa=0 sb=0 sd=0 mult=1 m=1
XMP_NINV_DP NONB_DP NB_DP VDD VDD sky130_fd_pr__pfet_g5v0d10v5 L=0.5 W=8 nf=1 ad=2.32 as=2.32
+ pd=16.58 ps=16.58 nrd=0.0362 nrs=0.0362 sa=0 sb=0 sd=0 mult=1 m=1
XMN_NINV_DP NONB_DP NB_DP VSS VSS sky130_fd_pr__nfet_g5v0d10v5 L=0.5 W=4 nf=1 ad=1.16 as=1.16
+ pd=8.58 ps=8.58 nrd=0.0725 nrs=0.0725 sa=0 sb=0 sd=0 mult=1 m=1
XMP_POFF_DP PG_DP PON_DP VDD VDD sky130_fd_pr__pfet_g5v0d10v5 L=0.5 W=20 nf=1 ad=5.8 as=5.8 pd=40.58
+ ps=40.58 nrd=0.0145 nrs=0.0145 sa=0 sb=0 sd=0 mult=1 m=1
XMN_PSW_DP PG_DP PON_DP XP_DP VSS sky130_fd_pr__nfet_g5v0d10v5 L=0.5 W=16 nf=1 ad=4.64 as=4.64
+ pd=32.58 ps=32.58 nrd=0.0181 nrs=0.0181 sa=0 sb=0 sd=0 mult=1 m=1
XMN_PSRC_DP XP_DP VBN VSS VSS sky130_fd_pr__nfet_g5v0d10v5 L=1 W=4 nf=1 ad=1.16 as=1.16 pd=8.58
+ ps=8.58 nrd=0.0725 nrs=0.0725 sa=0 sb=0 sd=0 mult=25 m=25
XMN_NOFF_DP NG_DP NONB_DP VSS VSS sky130_fd_pr__nfet_g5v0d10v5 L=0.5 W=20 nf=1 ad=5.8 as=5.8
+ pd=40.58 ps=40.58 nrd=0.0145 nrs=0.0145 sa=0 sb=0 sd=0 mult=1 m=1
XMP_NSW_DP NG_DP NONB_DP XN_DP VDD sky130_fd_pr__pfet_g5v0d10v5 L=0.5 W=8 nf=1 ad=2.32 as=2.32
+ pd=16.58 ps=16.58 nrd=0.0362 nrs=0.0362 sa=0 sb=0 sd=0 mult=1 m=1
XMP_NSRC_DP XN_DP VBP VDD VDD sky130_fd_pr__pfet_g5v0d10v5 L=1 W=8 nf=1 ad=2.32 as=2.32 pd=16.58
+ ps=16.58 nrd=0.0362 nrs=0.0362 sa=0 sb=0 sd=0 mult=8 m=8
XMP_KREP_DP KSP_DP PG_DP VDD VDD sky130_fd_pr__pfet_g5v0d10v5 L=0.5 W=10 nf=1 ad=2.9 as=2.9 pd=20.58
+ ps=20.58 nrd=0.029 nrs=0.029 sa=0 sb=0 sd=0 mult=1 m=1
XMN_KBIAS_DP KSP_DP VBN VSS VSS sky130_fd_pr__nfet_g5v0d10v5 L=1 W=4 nf=1 ad=1.16 as=1.16 pd=8.58
+ ps=8.58 nrd=0.0725 nrs=0.0725 sa=0 sb=0 sd=0 mult=1 m=1
XMP_KINV_DP KSPB_DP KSP_DP VDD VDD sky130_fd_pr__pfet_g5v0d10v5 L=0.5 W=2 nf=1 ad=0.58 as=0.58
+ pd=4.58 ps=4.58 nrd=0.145 nrs=0.145 sa=0 sb=0 sd=0 mult=1 m=1
XMN_KINV_DP KSPB_DP KSP_DP VSS VSS sky130_fd_pr__nfet_g5v0d10v5 L=0.5 W=1 nf=1 ad=0.29 as=0.29
+ pd=2.58 ps=2.58 nrd=0.29 nrs=0.29 sa=0 sb=0 sd=0 mult=1 m=1
XMN_KICK1_DP PG_DP PON_DP KPX_DP VSS sky130_fd_pr__nfet_g5v0d10v5 L=0.5 W=4 nf=1 ad=1.16 as=1.16
+ pd=8.58 ps=8.58 nrd=0.0725 nrs=0.0725 sa=0 sb=0 sd=0 mult=1 m=1
XMN_KICK2_DP KPX_DP KSPB_DP VSS VSS sky130_fd_pr__nfet_g5v0d10v5 L=0.5 W=4 nf=1 ad=1.16 as=1.16
+ pd=8.58 ps=8.58 nrd=0.0725 nrs=0.0725 sa=0 sb=0 sd=0 mult=1 m=1
XMN_KREPN_DP KSN_DP NG_DP VSS VSS sky130_fd_pr__nfet_g5v0d10v5 L=0.5 W=4 nf=1 ad=1.16 as=1.16
+ pd=8.58 ps=8.58 nrd=0.0725 nrs=0.0725 sa=0 sb=0 sd=0 mult=1 m=1
XMP_KBIASN_DP KSN_DP VBP VDD VDD sky130_fd_pr__pfet_g5v0d10v5 L=1 W=8 nf=1 ad=2.32 as=2.32 pd=16.58
+ ps=16.58 nrd=0.0362 nrs=0.0362 sa=0 sb=0 sd=0 mult=1 m=1
XMP_KINVN_DP KSNB_DP KSN_DP VDD VDD sky130_fd_pr__pfet_g5v0d10v5 L=0.5 W=2 nf=1 ad=0.58 as=0.58
+ pd=4.58 ps=4.58 nrd=0.145 nrs=0.145 sa=0 sb=0 sd=0 mult=1 m=1
XMN_KINVN_DP KSNB_DP KSN_DP VSS VSS sky130_fd_pr__nfet_g5v0d10v5 L=0.5 W=1 nf=1 ad=0.29 as=0.29
+ pd=2.58 ps=2.58 nrd=0.29 nrs=0.29 sa=0 sb=0 sd=0 mult=1 m=1
XMP_KICK1N_DP NG_DP NONB_DP KNX_DP VDD sky130_fd_pr__pfet_g5v0d10v5 L=0.5 W=4 nf=1 ad=1.16 as=1.16
+ pd=8.58 ps=8.58 nrd=0.0725 nrs=0.0725 sa=0 sb=0 sd=0 mult=1 m=1
XMP_KICK2N_DP KNX_DP KSNB_DP VDD VDD sky130_fd_pr__pfet_g5v0d10v5 L=0.5 W=4 nf=1 ad=1.16 as=1.16
+ pd=8.58 ps=8.58 nrd=0.0725 nrs=0.0725 sa=0 sb=0 sd=0 mult=1 m=1
XCP_DP PG_DP OUTI_DP sky130_fd_pr__cap_mim_m3_1 W=42 L=42 MF=1 m=1
XCN_DP NG_DP OUTI_DP sky130_fd_pr__cap_mim_m3_1 W=24 L=24 MF=1 m=1
XMP_OUT_DP OUTI_DP PG_DP VDD VDD sky130_fd_pr__pfet_g5v0d10v5 L=0.5 W=20 nf=1 ad=5.8 as=5.8 pd=40.58
+ ps=40.58 nrd=0.0145 nrs=0.0145 sa=0 sb=0 sd=0 mult=40 m=40
XMN_OUT_DP OUTI_DP NG_DP VSS VSS sky130_fd_pr__nfet_g5v0d10v5 L=0.5 W=20 nf=1 ad=5.8 as=5.8 pd=40.58
+ ps=40.58 nrd=0.0145 nrs=0.0145 sa=0 sb=0 sd=0 mult=13 m=13
XRSER_DP DP OUTI_DP sky130_fd_pr__res_generic_po W=20 L=10.8 m=1
XMP_PA1_DM PA_DM TXDM VDD VDD sky130_fd_pr__pfet_g5v0d10v5 L=0.5 W=2 nf=1 ad=0.58 as=0.58 pd=4.58
+ ps=4.58 nrd=0.145 nrs=0.145 sa=0 sb=0 sd=0 mult=1 m=1
XMP_PA2_DM PA_DM EN VDD VDD sky130_fd_pr__pfet_g5v0d10v5 L=0.5 W=2 nf=1 ad=0.58 as=0.58 pd=4.58
+ ps=4.58 nrd=0.145 nrs=0.145 sa=0 sb=0 sd=0 mult=1 m=1
XMN_PA1_DM PA_DM TXDM PAX_DM VSS sky130_fd_pr__nfet_g5v0d10v5 L=0.5 W=2 nf=1 ad=0.58 as=0.58 pd=4.58
+ ps=4.58 nrd=0.145 nrs=0.145 sa=0 sb=0 sd=0 mult=1 m=1
XMN_PA2_DM PAX_DM EN VSS VSS sky130_fd_pr__nfet_g5v0d10v5 L=0.5 W=2 nf=1 ad=0.58 as=0.58 pd=4.58
+ ps=4.58 nrd=0.145 nrs=0.145 sa=0 sb=0 sd=0 mult=1 m=1
XMP_PINV_DM PON_DM PA_DM VDD VDD sky130_fd_pr__pfet_g5v0d10v5 L=0.5 W=8 nf=1 ad=2.32 as=2.32
+ pd=16.58 ps=16.58 nrd=0.0362 nrs=0.0362 sa=0 sb=0 sd=0 mult=1 m=1
XMN_PINV_DM PON_DM PA_DM VSS VSS sky130_fd_pr__nfet_g5v0d10v5 L=0.5 W=4 nf=1 ad=1.16 as=1.16 pd=8.58
+ ps=8.58 nrd=0.0725 nrs=0.0725 sa=0 sb=0 sd=0 mult=1 m=1
XMP_NB1_DM NBX_DM TXDM VDD VDD sky130_fd_pr__pfet_g5v0d10v5 L=0.5 W=4 nf=1 ad=1.16 as=1.16 pd=8.58
+ ps=8.58 nrd=0.0725 nrs=0.0725 sa=0 sb=0 sd=0 mult=1 m=1
XMP_NB2_DM NB_DM ENB NBX_DM VDD sky130_fd_pr__pfet_g5v0d10v5 L=0.5 W=4 nf=1 ad=1.16 as=1.16 pd=8.58
+ ps=8.58 nrd=0.0725 nrs=0.0725 sa=0 sb=0 sd=0 mult=1 m=1
XMN_NB1_DM NB_DM TXDM VSS VSS sky130_fd_pr__nfet_g5v0d10v5 L=0.5 W=1 nf=1 ad=0.29 as=0.29 pd=2.58
+ ps=2.58 nrd=0.29 nrs=0.29 sa=0 sb=0 sd=0 mult=1 m=1
XMN_NB2_DM NB_DM ENB VSS VSS sky130_fd_pr__nfet_g5v0d10v5 L=0.5 W=1 nf=1 ad=0.29 as=0.29 pd=2.58
+ ps=2.58 nrd=0.29 nrs=0.29 sa=0 sb=0 sd=0 mult=1 m=1
XMP_NINV_DM NONB_DM NB_DM VDD VDD sky130_fd_pr__pfet_g5v0d10v5 L=0.5 W=8 nf=1 ad=2.32 as=2.32
+ pd=16.58 ps=16.58 nrd=0.0362 nrs=0.0362 sa=0 sb=0 sd=0 mult=1 m=1
XMN_NINV_DM NONB_DM NB_DM VSS VSS sky130_fd_pr__nfet_g5v0d10v5 L=0.5 W=4 nf=1 ad=1.16 as=1.16
+ pd=8.58 ps=8.58 nrd=0.0725 nrs=0.0725 sa=0 sb=0 sd=0 mult=1 m=1
XMP_POFF_DM PG_DM PON_DM VDD VDD sky130_fd_pr__pfet_g5v0d10v5 L=0.5 W=20 nf=1 ad=5.8 as=5.8 pd=40.58
+ ps=40.58 nrd=0.0145 nrs=0.0145 sa=0 sb=0 sd=0 mult=1 m=1
XMN_PSW_DM PG_DM PON_DM XP_DM VSS sky130_fd_pr__nfet_g5v0d10v5 L=0.5 W=16 nf=1 ad=4.64 as=4.64
+ pd=32.58 ps=32.58 nrd=0.0181 nrs=0.0181 sa=0 sb=0 sd=0 mult=1 m=1
XMN_PSRC_DM XP_DM VBN VSS VSS sky130_fd_pr__nfet_g5v0d10v5 L=1 W=4 nf=1 ad=1.16 as=1.16 pd=8.58
+ ps=8.58 nrd=0.0725 nrs=0.0725 sa=0 sb=0 sd=0 mult=25 m=25
XMN_NOFF_DM NG_DM NONB_DM VSS VSS sky130_fd_pr__nfet_g5v0d10v5 L=0.5 W=20 nf=1 ad=5.8 as=5.8
+ pd=40.58 ps=40.58 nrd=0.0145 nrs=0.0145 sa=0 sb=0 sd=0 mult=1 m=1
XMP_NSW_DM NG_DM NONB_DM XN_DM VDD sky130_fd_pr__pfet_g5v0d10v5 L=0.5 W=8 nf=1 ad=2.32 as=2.32
+ pd=16.58 ps=16.58 nrd=0.0362 nrs=0.0362 sa=0 sb=0 sd=0 mult=1 m=1
XMP_NSRC_DM XN_DM VBP VDD VDD sky130_fd_pr__pfet_g5v0d10v5 L=1 W=8 nf=1 ad=2.32 as=2.32 pd=16.58
+ ps=16.58 nrd=0.0362 nrs=0.0362 sa=0 sb=0 sd=0 mult=8 m=8
XMP_KREP_DM KSP_DM PG_DM VDD VDD sky130_fd_pr__pfet_g5v0d10v5 L=0.5 W=10 nf=1 ad=2.9 as=2.9 pd=20.58
+ ps=20.58 nrd=0.029 nrs=0.029 sa=0 sb=0 sd=0 mult=1 m=1
XMN_KBIAS_DM KSP_DM VBN VSS VSS sky130_fd_pr__nfet_g5v0d10v5 L=1 W=4 nf=1 ad=1.16 as=1.16 pd=8.58
+ ps=8.58 nrd=0.0725 nrs=0.0725 sa=0 sb=0 sd=0 mult=1 m=1
XMP_KINV_DM KSPB_DM KSP_DM VDD VDD sky130_fd_pr__pfet_g5v0d10v5 L=0.5 W=2 nf=1 ad=0.58 as=0.58
+ pd=4.58 ps=4.58 nrd=0.145 nrs=0.145 sa=0 sb=0 sd=0 mult=1 m=1
XMN_KINV_DM KSPB_DM KSP_DM VSS VSS sky130_fd_pr__nfet_g5v0d10v5 L=0.5 W=1 nf=1 ad=0.29 as=0.29
+ pd=2.58 ps=2.58 nrd=0.29 nrs=0.29 sa=0 sb=0 sd=0 mult=1 m=1
XMN_KICK1_DM PG_DM PON_DM KPX_DM VSS sky130_fd_pr__nfet_g5v0d10v5 L=0.5 W=4 nf=1 ad=1.16 as=1.16
+ pd=8.58 ps=8.58 nrd=0.0725 nrs=0.0725 sa=0 sb=0 sd=0 mult=1 m=1
XMN_KICK2_DM KPX_DM KSPB_DM VSS VSS sky130_fd_pr__nfet_g5v0d10v5 L=0.5 W=4 nf=1 ad=1.16 as=1.16
+ pd=8.58 ps=8.58 nrd=0.0725 nrs=0.0725 sa=0 sb=0 sd=0 mult=1 m=1
XMN_KREPN_DM KSN_DM NG_DM VSS VSS sky130_fd_pr__nfet_g5v0d10v5 L=0.5 W=4 nf=1 ad=1.16 as=1.16
+ pd=8.58 ps=8.58 nrd=0.0725 nrs=0.0725 sa=0 sb=0 sd=0 mult=1 m=1
XMP_KBIASN_DM KSN_DM VBP VDD VDD sky130_fd_pr__pfet_g5v0d10v5 L=1 W=8 nf=1 ad=2.32 as=2.32 pd=16.58
+ ps=16.58 nrd=0.0362 nrs=0.0362 sa=0 sb=0 sd=0 mult=1 m=1
XMP_KINVN_DM KSNB_DM KSN_DM VDD VDD sky130_fd_pr__pfet_g5v0d10v5 L=0.5 W=2 nf=1 ad=0.58 as=0.58
+ pd=4.58 ps=4.58 nrd=0.145 nrs=0.145 sa=0 sb=0 sd=0 mult=1 m=1
XMN_KINVN_DM KSNB_DM KSN_DM VSS VSS sky130_fd_pr__nfet_g5v0d10v5 L=0.5 W=1 nf=1 ad=0.29 as=0.29
+ pd=2.58 ps=2.58 nrd=0.29 nrs=0.29 sa=0 sb=0 sd=0 mult=1 m=1
XMP_KICK1N_DM NG_DM NONB_DM KNX_DM VDD sky130_fd_pr__pfet_g5v0d10v5 L=0.5 W=4 nf=1 ad=1.16 as=1.16
+ pd=8.58 ps=8.58 nrd=0.0725 nrs=0.0725 sa=0 sb=0 sd=0 mult=1 m=1
XMP_KICK2N_DM KNX_DM KSNB_DM VDD VDD sky130_fd_pr__pfet_g5v0d10v5 L=0.5 W=4 nf=1 ad=1.16 as=1.16
+ pd=8.58 ps=8.58 nrd=0.0725 nrs=0.0725 sa=0 sb=0 sd=0 mult=1 m=1
XCP_DM PG_DM OUTI_DM sky130_fd_pr__cap_mim_m3_1 W=42 L=42 MF=1 m=1
XCN_DM NG_DM OUTI_DM sky130_fd_pr__cap_mim_m3_1 W=24 L=24 MF=1 m=1
XMP_OUT_DM OUTI_DM PG_DM VDD VDD sky130_fd_pr__pfet_g5v0d10v5 L=0.5 W=20 nf=1 ad=5.8 as=5.8 pd=40.58
+ ps=40.58 nrd=0.0145 nrs=0.0145 sa=0 sb=0 sd=0 mult=40 m=40
XMN_OUT_DM OUTI_DM NG_DM VSS VSS sky130_fd_pr__nfet_g5v0d10v5 L=0.5 W=20 nf=1 ad=5.8 as=5.8 pd=40.58
+ ps=40.58 nrd=0.0145 nrs=0.0145 sa=0 sb=0 sd=0 mult=13 m=13
XRSER_DM DM OUTI_DM sky130_fd_pr__res_generic_po W=20 L=10.8 m=1
.ends
