* Derived by sim/make_se_receiver_tb.py; do not edit by hand.
* se-receiver-dm-thresholds -- sky130 single-ended D- receiver switching threshold and output levels
*
* Circuit body for `klt sim`. The design netlist (design/netlist/se_receiver_dm.spice)
* is appended by the runner (tb.json "include") and frozen into the immutable snapshot.
* The request supplies the .lib corner section, .temp and the supply sweep (vsup).
*
* Row (spec/usb2-phy.md section 6, "Single-ended receiver thresholds"): VIH > 2.0 V,
* VIL < 0.8 V. Read as: an input at or above 2.0 V must read high and an input at or
* below 0.8 V must read low, so the switching threshold must sit strictly inside
* (0.8 V, 2.0 V) and the output must be a valid logic level (not merely past mid-rail)
* everywhere in [0, 0.8] V and [2.0, 3.0] V. Both halves are measured (tb.json).
*
* Stimulus: one DC sweep of the line input DM from 0 V to 3.0 V in 1 mV steps
* (3001 points). 3.0 V is the lowest supply of the matrix, so the input never exceeds
* the receiver's own rail. The line source is ideal (zero source impedance).
* The D+ receiver is a separate cell with its own experiment
* (sim/se-receiver-dp-thresholds/).

vsup vdd 0 dc 3.3
vi vdd vddr dc 0
vin in 0 dc 0
ehalf half 0 vol='v(vdd)/2'
xrx vddr 0 in rxdm se_receiver_dm

* ---- included: ../../../design/netlist/se_receiver_dm.spice ----
* se_receiver_dm -- exported by design/export_netlist.sh from design/se_receiver_dm.sch (xschem, sky130 symbols)
* Do not edit: edit the schematic and re-run the export.
** sch_path: design/se_receiver_dm.sch
.subckt se_receiver_dm VDD VSS DM RXDM
*.iopin VDD
*.iopin VSS
*.ipin DM
*.iopin RXDM
XR1 VREF VDD VSS sky130_fd_pr__res_xhigh_po_1p41 L=19 mult=1 m=1
XR2 VSS VREF VSS sky130_fd_pr__res_xhigh_po_1p41 L=14 mult=1 m=1
XRBIAS IBIASN VDD VSS sky130_fd_pr__res_xhigh_po_1p41 L=140 mult=1 m=1
XMNBIAS IBIASN IBIASN VSS VSS sky130_fd_pr__nfet_g5v0d10v5 L=0.5 W=4 nf=1 ad=1.16 as=1.16 pd=8.58
+ ps=8.58 nrd=0.0725 nrs=0.0725 sa=0 sb=0 sd=0 mult=1 m=1
XMTAIL TAIL IBIASN VSS VSS sky130_fd_pr__nfet_g5v0d10v5 L=0.5 W=4 nf=1 ad=1.16 as=1.16 pd=8.58
+ ps=8.58 nrd=0.0725 nrs=0.0725 sa=0 sb=0 sd=0 mult=2 m=2
XMN_INA LOADDIODE DM TAIL VSS sky130_fd_pr__nfet_g5v0d10v5 L=0.5 W=10 nf=1 ad=2.9 as=2.9 pd=20.58
+ ps=20.58 nrd=0.029 nrs=0.029 sa=0 sb=0 sd=0 mult=2 m=2
XMN_INB AMPOUT VREF TAIL VSS sky130_fd_pr__nfet_g5v0d10v5 L=0.5 W=10 nf=1 ad=2.9 as=2.9 pd=20.58
+ ps=20.58 nrd=0.029 nrs=0.029 sa=0 sb=0 sd=0 mult=2 m=2
XMP_LOADA LOADDIODE LOADDIODE VDD VDD sky130_fd_pr__pfet_g5v0d10v5 L=0.5 W=10 nf=1 ad=2.9 as=2.9
+ pd=20.58 ps=20.58 nrd=0.029 nrs=0.029 sa=0 sb=0 sd=0 mult=4 m=4
XMP_LOADB AMPOUT LOADDIODE VDD VDD sky130_fd_pr__pfet_g5v0d10v5 L=0.5 W=10 nf=1 ad=2.9 as=2.9
+ pd=20.58 ps=20.58 nrd=0.029 nrs=0.029 sa=0 sb=0 sd=0 mult=4 m=4
XMP_B1 BUF1 AMPOUT VDD VDD sky130_fd_pr__pfet_g5v0d10v5 L=0.5 W=20 nf=1 ad=5.8 as=5.8 pd=40.58
+ ps=40.58 nrd=0.0145 nrs=0.0145 sa=0 sb=0 sd=0 mult=1 m=1
XMN_B1 BUF1 AMPOUT VSS VSS sky130_fd_pr__nfet_g5v0d10v5 L=0.5 W=2 nf=1 ad=0.58 as=0.58 pd=4.58
+ ps=4.58 nrd=0.145 nrs=0.145 sa=0 sb=0 sd=0 mult=1 m=1
XMP_B2 RXDM BUF1 VDD VDD sky130_fd_pr__pfet_g5v0d10v5 L=0.5 W=10 nf=1 ad=2.9 as=2.9 pd=20.58
+ ps=20.58 nrd=0.029 nrs=0.029 sa=0 sb=0 sd=0 mult=1 m=1
XMN_B2 RXDM BUF1 VSS VSS sky130_fd_pr__nfet_g5v0d10v5 L=0.5 W=5 nf=1 ad=1.45 as=1.45 pd=10.58
+ ps=10.58 nrd=0.058 nrs=0.058 sa=0 sb=0 sd=0 mult=1 m=1
.ends
