* se-receiver-dp-pex -- sky130 single-ended D+ receiver thresholds, post-layout (klt pex)
*
* Post-layout counterpart of sim/se-receiver-dp-thresholds: identical circuit body, measurements and
* checks. The single .include below names the schematic-leg DUT shim (se_receiver_dp_pex_dut.spice:
* design/netlist/se_receiver_dp.spice with its .subckt declaration line reordered to the
* extracted header's pin order) -- the swap point klt pex re-points at the extracted
* netlist for the extracted-side leg. Every DUT instance line's nets are written in
* that same order, so one positional instance line serves both legs with the same
* net-to-pin mapping. The request supplies the .lib corner section, .temp and the
* supply sweep (vsup).
*
* Stimulus (unchanged from the committed bench): one DC sweep of the line input DP
* from 0 V to 3.0 V in 1 mV steps (3001 points), ideal source. 3.0 V is the lowest
* matrix supply, so the input never exceeds the receiver's own rail.

.include "se_receiver_dp_pex_dut.spice"

vsup vdd 0 dc 3.3
vi vdd vddr dc 0
vin in 0 dc 0
ehalf half 0 vol='v(vdd)/2'
xrx in rxdp vddr 0 se_receiver_dp

* ---- included: se_receiver_dp_pex_dut.spice ----
* se_receiver_dp_pex_dut.spice -- schematic-leg DUT for sim/se-receiver-dp-pex
*
* design/netlist/se_receiver_dp.spice with its .subckt declaration line's pin
* list reordered from the schematic symbol order (VDD VSS DP RXDP) to the order klt
* extract writes the extracted header in (DP RXDP VDD VSS, alphabetical; confirmed by a
* klt pex --extract-only probe of the committed GDS). klt pex reuses one positional
* instance line on both legs, so both sides must declare the same pin sequence, and
* the deck's instance lines carry their nets in the same order (same net-to-pin
* mapping on both legs). The reordered declaration is electrically identical (SPICE
* maps instance positions to the declared pin names) and every other byte is identical
* to the pinned netlist; the schematic leg must reproduce the committed record named in
* the pex run.py gate before any delta is read.
* se_receiver_dp -- exported by design/export_netlist.sh from design/se_receiver_dp.sch (xschem, sky130 symbols)
* Do not edit: edit the schematic and re-run the export.
** sch_path: design/se_receiver_dp.sch
.subckt se_receiver_dp DP RXDP VDD VSS
*.iopin VDD
*.iopin VSS
*.ipin DP
*.iopin RXDP
XR1 VREF VDD VSS sky130_fd_pr__res_xhigh_po_1p41 L=19 mult=1 m=1
XR2 VSS VREF VSS sky130_fd_pr__res_xhigh_po_1p41 L=14 mult=1 m=1
XRBIAS IBIASN VDD VSS sky130_fd_pr__res_xhigh_po_1p41 L=140 mult=1 m=1
XMNBIAS IBIASN IBIASN VSS VSS sky130_fd_pr__nfet_g5v0d10v5 L=0.5 W=4 nf=1 ad=1.16 as=1.16 pd=8.58
+ ps=8.58 nrd=0.0725 nrs=0.0725 sa=0 sb=0 sd=0 mult=1 m=1
XMTAIL TAIL IBIASN VSS VSS sky130_fd_pr__nfet_g5v0d10v5 L=0.5 W=4 nf=1 ad=1.16 as=1.16 pd=8.58
+ ps=8.58 nrd=0.0725 nrs=0.0725 sa=0 sb=0 sd=0 mult=2 m=2
XMN_INA LOADDIODE DP TAIL VSS sky130_fd_pr__nfet_g5v0d10v5 L=0.5 W=10 nf=1 ad=2.9 as=2.9 pd=20.58
+ ps=20.58 nrd=0.029 nrs=0.029 sa=0 sb=0 sd=0 mult=2 m=2
XMN_INB AMPOUT VREF TAIL VSS sky130_fd_pr__nfet_g5v0d10v5 L=0.5 W=10 nf=1 ad=2.9 as=2.9 pd=20.58
+ ps=20.58 nrd=0.029 nrs=0.029 sa=0 sb=0 sd=0 mult=2 m=2
XMP_LOADA LOADDIODE LOADDIODE VDD VDD sky130_fd_pr__pfet_g5v0d10v5 L=0.5 W=10 nf=1 ad=2.9 as=2.9
+ pd=20.58 ps=20.58 nrd=0.029 nrs=0.029 sa=0 sb=0 sd=0 mult=4 m=4
XMP_LOADB AMPOUT LOADDIODE VDD VDD sky130_fd_pr__pfet_g5v0d10v5 L=0.5 W=10 nf=1 ad=2.9 as=2.9
+ pd=20.58 ps=20.58 nrd=0.029 nrs=0.029 sa=0 sb=0 sd=0 mult=4 m=4
XMP_B1 BUF1 AMPOUT VDD VDD sky130_fd_pr__pfet_g5v0d10v5 L=0.5 W=20 nf=1 ad=5.8 as=5.8 pd=40.58
+ ps=40.58 nrd=0.0145 nrs=0.0145 sa=0 sb=0 sd=0 mult=1 m=1
XMN_B1 BUF1 AMPOUT VSS VSS sky130_fd_pr__nfet_g5v0d10v5 L=0.5 W=2 nf=1 ad=0.58 as=0.58 pd=4.58
+ ps=4.58 nrd=0.145 nrs=0.145 sa=0 sb=0 sd=0 mult=1 m=1
XMP_B2 RXDP BUF1 VDD VDD sky130_fd_pr__pfet_g5v0d10v5 L=0.5 W=10 nf=1 ad=2.9 as=2.9 pd=20.58
+ ps=20.58 nrd=0.029 nrs=0.029 sa=0 sb=0 sd=0 mult=1 m=1
XMN_B2 RXDP BUF1 VSS VSS sky130_fd_pr__nfet_g5v0d10v5 L=0.5 W=5 nf=1 ad=1.45 as=1.45 pd=10.58
+ ps=10.58 nrd=0.058 nrs=0.058 sa=0 sb=0 sd=0 mult=1 m=1
.ends
