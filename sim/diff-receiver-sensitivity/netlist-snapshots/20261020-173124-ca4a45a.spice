* diff-receiver-sensitivity -- sky130 differential receiver sensitivity at three common-mode points
*
* Circuit body for `klt sim`. The design netlist (design/netlist/differential_receiver.spice)
* is appended by the runner (tb.json "include") and frozen into the immutable snapshot.
* The request supplies the .lib corner section, .temp and the supply sweep (vsup).
*
* One receiver instance per common-mode point (0.8 / 1.65 / 2.5 V), all driven by the
* same differential sweep, so each of the 45 PVT corners yields all three common-mode
* points. Definition:   DP = VCM + VDIFF/2      DM = VCM - VDIFF/2     VDIFF = DP - DM
* VDIFF is swept -400 mV ... +400 mV in 1 mV steps (both polarities, 801 points).
* Common-mode sources are ideal (zero source impedance); the supply is the swept I/O rail.

vsup vdd 0 dc 3.3
vd vd 0 dc 0
ehalf half 0 vol='v(vdd)/2'

* ---- common mode 0.8 V ----
vi08 vdd vdd08 dc 0
vcm08 cm08 0 dc 0.8
edp08 dp08 0 vol='v(cm08)+v(vd)/2'
edm08 dm08 0 vol='v(cm08)-v(vd)/2'
x08 vdd08 0 dp08 dm08 rxd08 differential_receiver

* ---- common mode 1.65 V ----
vi165 vdd vdd165 dc 0
vcm165 cm165 0 dc 1.65
edp165 dp165 0 vol='v(cm165)+v(vd)/2'
edm165 dm165 0 vol='v(cm165)-v(vd)/2'
x165 vdd165 0 dp165 dm165 rxd165 differential_receiver

* ---- common mode 2.5 V ----
vi25 vdd vdd25 dc 0
vcm25 cm25 0 dc 2.5
edp25 dp25 0 vol='v(cm25)+v(vd)/2'
edm25 dm25 0 vol='v(cm25)-v(vd)/2'
x25 vdd25 0 dp25 dm25 rxd25 differential_receiver

* ---- included: ../../../design/netlist/differential_receiver.spice ----
* differential_receiver -- exported by design/export_netlist.sh from design/differential_receiver.sch (xschem, sky130 symbols)
* Do not edit: edit the schematic and re-run the export.
** sch_path: design/differential_receiver.sch
.subckt differential_receiver VDD VSS DP DM RXD
*.iopin VDD
*.iopin VSS
*.ipin DP
*.ipin DM
*.iopin RXD
XRBIAS IBIASN VDD VSS sky130_fd_pr__res_xhigh_po_1p41 L=140 mult=1 m=1
XMNBIAS IBIASN IBIASN VSS VSS sky130_fd_pr__nfet_g5v0d10v5 L=0.5 W=4 nf=1 ad=1.16 as=1.16 pd=8.58
+ ps=8.58 nrd=0.0725 nrs=0.0725 sa=0 sb=0 sd=0 mult=1 m=1
XMTAIL TAIL IBIASN VSS VSS sky130_fd_pr__nfet_g5v0d10v5 L=0.5 W=4 nf=1 ad=1.16 as=1.16 pd=8.58
+ ps=8.58 nrd=0.0725 nrs=0.0725 sa=0 sb=0 sd=0 mult=2 m=2
XMN_INA LOADDIODE DP TAIL VSS sky130_fd_pr__nfet_g5v0d10v5 L=0.5 W=10 nf=1 ad=2.9 as=2.9 pd=20.58
+ ps=20.58 nrd=0.029 nrs=0.029 sa=0 sb=0 sd=0 mult=2 m=2
XMN_INB AMPOUT DM TAIL VSS sky130_fd_pr__nfet_g5v0d10v5 L=0.5 W=10 nf=1 ad=2.9 as=2.9 pd=20.58
+ ps=20.58 nrd=0.029 nrs=0.029 sa=0 sb=0 sd=0 mult=2 m=2
XMP_LOADA LOADDIODE LOADDIODE VDD VDD sky130_fd_pr__pfet_g5v0d10v5 L=0.5 W=10 nf=1 ad=2.9 as=2.9
+ pd=20.58 ps=20.58 nrd=0.029 nrs=0.029 sa=0 sb=0 sd=0 mult=4 m=4
XMP_LOADB AMPOUT LOADDIODE VDD VDD sky130_fd_pr__pfet_g5v0d10v5 L=0.5 W=10 nf=1 ad=2.9 as=2.9
+ pd=20.58 ps=20.58 nrd=0.029 nrs=0.029 sa=0 sb=0 sd=0 mult=4 m=4
XMP_B1 BUF1 AMPOUT VDD VDD sky130_fd_pr__pfet_g5v0d10v5 L=0.5 W=20 nf=1 ad=5.8 as=5.8 pd=40.58
+ ps=40.58 nrd=0.0145 nrs=0.0145 sa=0 sb=0 sd=0 mult=1 m=1
XMN_B1 BUF1 AMPOUT VSS VSS sky130_fd_pr__nfet_g5v0d10v5 L=0.5 W=2 nf=1 ad=0.58 as=0.58 pd=4.58
+ ps=4.58 nrd=0.145 nrs=0.145 sa=0 sb=0 sd=0 mult=1 m=1
XMP_B2 RXD BUF1 VDD VDD sky130_fd_pr__pfet_g5v0d10v5 L=0.5 W=10 nf=1 ad=2.9 as=2.9 pd=20.58 ps=20.58
+ nrd=0.029 nrs=0.029 sa=0 sb=0 sd=0 mult=1 m=1
XMN_B2 RXD BUF1 VSS VSS sky130_fd_pr__nfet_g5v0d10v5 L=0.5 W=5 nf=1 ad=1.45 as=1.45 pd=10.58
+ ps=10.58 nrd=0.058 nrs=0.058 sa=0 sb=0 sd=0 mult=1 m=1
.ends
